Simple voltage divider
V1 n1 0 DC 8
I1 0 n3 DC 1m
R1 n1 n2 1k
R2 n2 n3 2k
R3 n2 0 2k
.dc
.end
