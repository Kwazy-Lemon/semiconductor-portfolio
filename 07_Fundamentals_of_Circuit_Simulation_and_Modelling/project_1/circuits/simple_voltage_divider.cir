Simple voltage divider
V1 n1 0 DC 8
I1 0 n3 DC 1m
R1 n1 n2 1k
R2 n2 n3 2k
R3 n2 0 2k
R4 n3 0 4k
R5 n4 n5 1k
R6 n5 0 2k
R7 n5 n6 1k
C1 n2 0 2.2u
L1 n6 0 5m
VCVS1 n4 0 n2 n3 1.5
CCCS1 n5 0 V1 0.5
.dc
.end
