Simple voltage divider
V1 n1 0 DC 10
R1 n1 n2 1000
R2 n2 n3 2000
R3 n2 0 2000
R4 n3 0 4000
R5 n4 n5 1000
R6 n5 0 2000
R7 n5 n6 1000
I1 0 n3 1m
C1 n2 0 4.7u
L1 n6 0 10m
VCCS1 n1 0 n2 n3 0.5m
CCVS1 n4 0 n1 0 1k
.dc
.end
