* 1 mA diode circuit
Iin 0 n1 DC 0.001
D1 n1 n2
R n2 0 50
.dc
.end
